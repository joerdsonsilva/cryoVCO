** sch_path: /home/Joerdson/IHP-Open-PDK/ihp-sg13g2/libs.tech/xschem/LC_VCO.sch
**.subckt LC_VCO LON LOP VCC ICC GND VCTR
*.iopin LON
*.iopin LOP
*.iopin VCC
*.iopin ICC
*.iopin GND
*.iopin VCTR
XMN3 LOP LON net1 net2 sg13_lv_nmos w=40.0u l=0.13u ng=5 m=1
XMN4 LON LOP net1 net2 sg13_lv_nmos w=40.0u l=0.13u ng=5 m=1
XMN1 ICC ICC GND GND sg13_lv_nmos w=120.0u l=0.13u ng=15 m=1
XMN2 net1 ICC GND GND sg13_lv_nmos w=120.0u l=0.13u ng=15 m=1
XC1 VCC LOP cap_cmim w=8.73e-6 l=9.42e-6 m=1
XR1 LOP VCC rppd w=10.77e-6 l=8.92e-6 m=1 b=0
XC2 VCC LON cap_cmim w=8.73e-6 l=9.42e-6 m=1
XR2 LON VCC rppd w=10.77e-6 l=8.92e-6 m=1 b=0
L1 VCC LOP 2.006n m=1
L2 VCC LON 2.006n m=1
XCvar LOP VCTR LON net2 sg13_hv_svaricap W=9.74e-6 L=0.8e-6 Nx=2
**.ends
.end
